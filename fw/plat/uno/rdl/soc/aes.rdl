// Copyright (c) Microsoft Corporation.
// Licensed under the MIT License.
//
// AES -- Symmetric Block Cipher Accelerator
//
// Single-instance hardware accelerator supporting AES-ECB/CBC/CTR etc.
// (modes encoded in command descriptor cmd_code).
//
// MMIO layout (2 registers, 0x08 used out of 0x1000):
//   COMMAND      @ 0x000   (RW32)  Write descriptor AXI address to start op
//   STATUS       @ 0x004   (RO32)  BUSY, COMPLETE, ERROR_*, NOT_OWNER
//
// Address map:
//   AES              @ 0xA020_0000  (single instance)
//
// Firmware flow:
//   1. Build AesCmdDesc (24 B) in GSRAM.
//   2. Write descriptor's AXI address to COMMAND register (doorbell).
//   3. Engine fetches descriptor, executes mode, reads input, writes
//      output, posts STATUS.
//   4. Done or Error IRQ fires (silicon RDL pending for vectors).
//
// -- COMMAND -- descriptor doorbell --

reg aes_command_t {                                         // AES: command
    desc = "Descriptor doorbell. Writing this register triggers the
            engine to fetch the 24-byte AesCmdDesc descriptor located
            at the written AXI address and start executing the
            requested operation. The descriptor must be 4-byte aligned
            and remain valid until STATUS reports completion.";

    field {
        sw = rw;
        hw = r;
        desc = "AXI address of the AesCmdDesc descriptor. Reads return
                the last-written value (not consumed by hardware on
                read). Writes act as the doorbell that triggers the
                engine to fetch the descriptor.";
    } DESC_ADDR[31:0] = 0x0;                            // AES: desc_addr
};


// -- STATUS -- completion + error bits --

reg aes_status_t {                                          // AES: status
    desc = "Engine status. Polled by firmware between submit and
            completion; latched by the engine on every state
            transition. A Done or Error IRQ fires on every command
            completion (positive and negative).";

    field {
        sw = r;
        hw = w;
        desc = "Engine is currently processing a command. Cleared on
                completion (success or error). Firmware must NOT
                write the COMMAND register while BUSY is set.";
    } BUSY[0:0] = 0x0;                                  // AES: busy

    field {
        sw = r;
        hw = w;
        desc = "Engine successfully finished the most recent command.
                Mutually exclusive with the ERROR_* bits.";
    } COMPLETE[1:1] = 0x0;                              // AES: complete

    field {
        sw = r;
        hw = w;
        desc = "Engine could not decode the command structure
                successfully (invalid opcode, bad descriptor layout).";
    } ERROR_CMD[2:2] = 0x0;                             // AES: error_cmd

    field {
        sw = r;
        hw = w;
        desc = "Engine encountered an error initiating an AXI bus
                transaction (e.g. SLVERR / DECERR on a result, input
                buffer, or descriptor fetch).";
    } ERROR_BUS[3:3] = 0x0;                             // AES: error_bus

    field {
        sw = r;
        hw = w;
        desc = "Engine detected an internal fault while working on the
                operation (parity, lane-fault, or engine-fault).";
    } ERROR_FAULT[4:4] = 0x0;                           // AES: error_fault

    field {
        sw = r;
        hw = w;
        desc = "Engine is/was working on a command initiated by a
                different bus master than the one reading the STATUS
                register. Driver masks this bit out of completion
                decode (mirrors UPKA/SHA pattern).";
    } NOT_OWNER[5:5] = 0x0;                             // AES: not_owner

    field { sw = r; } RSVD_0[31:6] = 0x0;
};


// -- Address Map (single AES instance) --

addrmap aes {
    name = "AES";
    desc = "AES symmetric block cipher accelerator (single instance).
             Descriptor-driven dispatch model identical to UPKA/SHA.
             Base address 0xA020_0000.";

    default hw = na;
    default sw = rw;

    aes_command_t       COMMAND     @ 0x00;
    aes_status_t        STATUS      @ 0x04;
};

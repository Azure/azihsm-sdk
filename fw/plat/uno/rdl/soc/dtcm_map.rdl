// Copyright (c) Microsoft Corporation.
// Licensed under the MIT License.
//
// DTCM address map (hsm_dtcm).
//
// Single unified address map for HSM local DTCM at base 0x2000_0000
// (256 KB total). The lower portion is for linker-placed stack/.bss;
// the upper portion holds fixed firmware data structures:
//
//   0x2002_EC00  DTCM_IO_BUF[33]    (49.5 KB, per-IO NonDma scratch, 1.5 KB each)
//   0x2003_B400  DEV_ID_CERT_BLOB   (16 KB, HSP-pushed device-id cert CBLOB)
//   0x2003_F400  CRASHDUMP_BASE     (1024 B)
//   0x2003_F800  CORE_RUN_STATUS    (4 B)
//
// memory.x should set RAM LENGTH = 187K to prevent the linker from
// placing .bss/stack into the reserved upper region.


// ══════════════════════════════════════════════════════════════
// Per-IO NonDma scratch buffers
// ══════════════════════════════════════════════════════════════

mem dtcm_io_buf_t {
    desc = "1.5KB per-slot CPU-only scratch buffer. Indexed 1:1 with IO_SQ.
            Shrunk from 2 KB to free the DTCM tail for DEV_ID_CERT_BLOB;
            NonDma scratch has no callers today so 1.5 KB is ample.";
    mementries = 384;   // 384 × 32 bits = 1536 B = 1.5 KB
    memwidth = 32;
};


// ══════════════════════════════════════════════════════════════
// Device-ID cert-chain CBLOB (HSP boot-push)
// ══════════════════════════════════════════════════════════════

mem dev_id_cert_blob_t {
    desc = "Device-id certificate-chain CBLOB (16 KB). The HSP packs the
            root/intermediate/device-id DER chain here at boot (fixed global
            0x6063_B400) before releasing the CP cores; the HSM serves
            GetCertChainInfo/GetCertificate for the dev-id chain from local
            DTCM with no IPC. Read-only from the HSM. See the cert_blob crate
            for the container layout.";
    mementries = 4096;  // 4096 × 32 bits = 16384 B = 16 KB
    memwidth   = 32;
};


// ══════════════════════════════════════════════════════════════
// Crashdump + Core Status
// ══════════════════════════════════════════════════════════════

mem crashdump_base_t {
    desc = "Crashdump staging buffer (1024 B). Exception handler stages
            register state + stack trace here for SP collection.";
    mementries = 256;   // 256 × 32 bits = 1024 B
    memwidth   = 32;
};

reg core_run_status_t {
    name = "Core Run Status";
    desc = "Liveliness heartbeat. HSM writes 1 periodically; SP reads
            then zeroes. Zero on next poll = hung.";
    field { sw = rw; hw = na; } ALIVE[31:0] = 0x0;
};


// ══════════════════════════════════════════════════════════════
// Address Map
// ══════════════════════════════════════════════════════════════

addrmap hsm_dtcm {
    name = "HSM DTCM";
    desc = "HSM local DTCM (256 KB at 0x2000_0000). Upper region holds
             per-IO scratch buffers and status/crashdump registers.
             Lower 189 KB is linker-managed (stack + .bss).";

    default hw = na;
    default sw = rw;

    // Per-IO NonDma scratch (33 × 1.5 KB = 49.5 KB; slots 0..31 host, 32 admin).
    // Stays 33 (not 34): the self-test slot (SRAM index 33) uses DMA buffers
    // only — all crypto drivers allocate from the SRAM (Dma) heap and never the
    // DTCM (NonDma) heap — so it needs no DTCM scratch.
    // Ends at 0x3B200, below the DEV_ID_CERT_BLOB region.
    dtcm_io_buf_t    DTCM_IO_BUF[33]   @ 0x2EC00 += 0x600;

    // Device-id cert-chain CBLOB — HSP boot-push target (fixed global 0x6063_B400).
    dev_id_cert_blob_t DEV_ID_CERT_BLOB @ 0x3B400;

    // Crashdump + heartbeat
    crashdump_base_t  CRASHDUMP_BASE    @ 0x3F400;
    core_run_status_t CORE_RUN_STATUS   @ 0x3F800;
};
